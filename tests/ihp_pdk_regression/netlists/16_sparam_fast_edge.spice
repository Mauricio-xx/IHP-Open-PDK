* VF Transient: Fast edge (50ps rise) stress test
* Tests VF with wideband content (rise ~50ps => BW ~7GHz)
* The RC lowpass (3dB at 1.17GHz) should filter this
* Expected: output is smoothed, peak less than input
.options reltol=1e-3 itl4=200
V1 1 0 PULSE(0 1 0.5n 0.05n 0.05n 2n 10n)
R1 1 2 50
A1 [2 0 3 0] lowpass_fast
.model lowpass_fast sparam file="/pdk/ihp-sg13g2/libs.tech/ngspice/touchstone/rc_lowpass.s2p"
R2 3 0 50
.tran 0.005n 20n
.control
run
wrdata /tests/results/16_sparam_fast_edge.csv v(2) v(3)
.endc
.end
