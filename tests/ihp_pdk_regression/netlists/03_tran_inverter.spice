* CMOS Inverter Transient
Vin in GND pulse(0 1.2 0 100p 100p 2n 4n)
Vdd dd GND 1.2
XM1 out in GND GND sg13_lv_nmos w=1.0u l=0.45u ng=1 m=1
XM2 out in dd dd sg13_lv_pmos w=1.0u l=0.45u ng=1 m=1
.lib cornerMOSlv.lib mos_tt
.param temp=27
.control
save all
tran 10p 20n
wrdata /tests/results/03_tran_inverter.csv v(in) v(out)
.endc
.GLOBAL GND
.end
