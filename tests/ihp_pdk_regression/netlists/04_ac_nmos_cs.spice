* NMOS Common Source AC Analysis
Vdd dd GND 1.2
Rd dd out 1k
Vin in GND dc 0.6 ac 1
XM1 out in GND GND sg13_lv_nmos w=10u l=0.45u ng=1 m=1
.lib cornerMOSlv.lib mos_tt
.param temp=27
.control
save all
ac dec 10 1k 100G
wrdata /tests/results/04_ac_nmos_cs.csv v(out)
.endc
.GLOBAL GND
.end
